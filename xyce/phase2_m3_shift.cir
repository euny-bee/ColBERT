* M3 Phase2 Vth=0.6102
.INCLUDE igzo_smooth_k5.sub
VV1  v1n 0 DC 0.0
VV2  v2n 0 DC 3.0
VV3  v3n 0 DC -3.0
VV4  v4n 0 DC 0.0
V4B  v4bn 0 DC 1.0
BSN  sn  0 V={1.6102 - V(v4n)}
XM5  v1n v2n mid IGZO_SMOOTH_K5
XM4  mid v3n sn  IGZO_SMOOTH_K5
XM3  mid sn  v4bn IGZO_SMOOTH_K5 PARAMS: V0=0.6102
RMID mid 0 10T
.DC VV4 -1 2 0.02
.PRINT DC FORMAT=CSV V(v4n) V(sn) V(mid) I(V4B)
.END
