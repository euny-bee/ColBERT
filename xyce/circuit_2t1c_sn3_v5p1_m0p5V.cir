* 2T1C  Vth-0.5V model,  V(SN)_IC=3V, V3=3V, V4=0V, V5=+1V
.TITLE 2T1C Vth-0p5V V5=1V
.INCLUDE igzo_smooth_m0p5V.sub
VV3  v3n  0  DC 3.0
VV4  v4n  0  DC 0.0
VV5  v5n  0  DC 1.0
C1  sn  v4n  100f  IC=3
XM1  mid  v3n  sn   IGZO_SMOOTH_M0P5V
XM0  mid  sn   v5n  IGZO_SMOOTH_M0P5V
RBLEED  sn   0  10G
RMID    mid  0  10G
CMID    mid  0  1f
CSN     sn   0  1f
.IC  V(sn)=3  V(mid)=0
.OPTIONS TIMEINT METHOD=TRAP ABSTOL=1e-13 RELTOL=1e-3
.OPTIONS DEVICE GMIN=1e-15
.TRAN 5n 50000n UIC
.PRINT TRAN FORMAT=CSV  TIME  V(sn)  V(mid)
.END
