* Phase 2 M0  Vth+0.5V shift: V0=0.6102V
* BSN = V4 + (V0_shift - V5) = V4 -0.3898  (Vth-cancelled turn-on still at V4=V5=1V)
.INCLUDE igzo_smooth_k5.sub
VV1  v1n  0  DC 0.0
VV2  v2n  0  DC 3.0
VV3  v3n  0  DC -3.0
VV4  v4n  0  DC 0.0
V5B  v5bn 0  DC 1.0
BSN  sn   0  V={V(v4n) + -0.3898}
XM2  v1n  v2n  mid  IGZO_SMOOTH_K5
XM1  mid  v3n  sn   IGZO_SMOOTH_K5
XM0  mid  sn   v5bn IGZO_SMOOTH_K5 PARAMS: V0=0.6102
RMID mid  0  10T
.DC VV4 -1 2 0.02
.PRINT DC FORMAT=CSV V(v4n) V(sn) V(mid) I(V5B)
.END
