* ============================================================
* Dual 3T1C (6T2C) -- Phase1(precharge) -> Phase2(store) -- die4
* [실험] VCOMP를 고정 3V가 아니라 Vth_final+5V로 스케일 -> M1이 Vth와 무관하게
*        항상 충분히 켜져있다고 가정했을 때 SN이 -V1+Vth 이상식에 얼마나 가까워지는지 확인
* ============================================================

.TITLE Phase1-2 dual die4 -- VCOMP scaled with Vth (always strongly on)

.INCLUDE igzo_die4.sub

.PARAM Vth_final = 0.03
.STEP Vth_final LIST 0.03 0.53 1.03 2.03 3.03

VVML    vml    0  DC 0.0
VVCOMP  vcompn 0  DC {Vth_final+5.0}
VVREAD  vreadn 0  PWL(0 3.0  0.2u 3.0  0.2001u -3.0  500000u -3.0)
VBL_L   vbl_l  0  PWL(0 0.0  0.2u 0.0  0.2001u -1.0  500000u -1.0)
VBL_R   vbl_r  0  PWL(0 0.0  0.2u 0.0  0.2001u  1.0  500000u  1.0)

XM2  vml    vreadn  midL  IGZO_DIE4  PARAMS: V0={Vth_final}
XM1  midL   vcompn  sn    IGZO_DIE4  PARAMS: V0={Vth_final}
XM0  midL   sn      vbl_l IGZO_DIE4  PARAMS: V0={Vth_final}
CSN  sn     0  100f  IC=-1.5

XM5  vml    vreadn  midR  IGZO_DIE4  PARAMS: V0={Vth_final}
XM4  midR   vcompn  snb   IGZO_DIE4  PARAMS: V0={Vth_final}
XM3  midR   snb     vbl_r IGZO_DIE4  PARAMS: V0={Vth_final}
CSNB snb    0  100f  IC=-1.5

RLEAK_L   sn    0  10G
RLEAK_R   snb   0  10G
RMID_L    midL  0  10G
RMID_R    midR  0  10G

.OPTIONS TIMEINT METHOD=TRAP ABSTOL=1e-14 RELTOL=1e-4
.OPTIONS NONLIN CONTINUATION=1

.TRAN 1n 500000u UIC

.PRINT TRAN FORMAT=CSV  TIME  V(sn)  V(snb)  V(midL)  V(midR)  V(vreadn)  V(vcompn)  V(vbl_l)  V(vbl_r)
+ I(VVML)  I(VVCOMP)  I(VVREAD)  I(VBL_L)  I(VBL_R)

.END
