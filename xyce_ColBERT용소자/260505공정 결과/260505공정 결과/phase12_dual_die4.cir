* ============================================================
* Dual 3T1C (6T2C) -- Phase1(precharge) -> Phase2(store) 연속 -- die4
*
* VREAD: 0~t1=0.2us 구간 3V(Phase1) -> t1 이후 -3V(Phase2)
* VCOMP: 항상 3V (M1/M4는 계속 켜짐)
* VML:   항상 0V (M2/M5는 Phase1에서만 유효, Phase2에서는 VREAD=-3V로 꺼짐)
* bitline: VBL_L=-1.0V, VBL_R=+1.0V (M0/M3 source, 항상 인가)
*
* 왼쪽: VML--M2(VREAD)--midL--M1(VCOMP)--SN--C(100fF)--GND
*       SN--M0(gate=SN,drain=midL,source=VBL_L)  (M0도 항상 존재, Phase2에서 지배적)
* 오른쪽: 대칭 (M5,M4,SN_bar,M3,VBL_R)
*
* Vth(V0)를 .STEP PARAM으로 5개 값 스윕: 0.03,0.53,1.03,2.03,3.03V
* ============================================================

.TITLE Phase1-2 dual die4 -- write settling, Vth sweep

.INCLUDE igzo_die4.sub

.PARAM Vth_final = 0.03
.STEP Vth_final LIST 0.03 0.53 1.03 2.03 3.03

VVML    vml    0  DC 0.0
VVCOMP  vcompn 0  DC 3.0
VVREAD  vreadn 0  PWL(0 3.0  0.2u 3.0  0.2001u -3.0  500000u -3.0)
* bitline: Phase1(0~t1) 동안 중립(0V), Phase2(t1 이후) 부터 ∓1.0V(V1=1.0V) 인가
VBL_L   vbl_l  0  PWL(0 0.0  0.2u 0.0  0.2001u -1.0  500000u -1.0)
VBL_R   vbl_r  0  PWL(0 0.0  0.2u 0.0  0.2001u  1.0  500000u  1.0)

* 왼쪽 브랜치
XM2  vml    vreadn  midL  IGZO_DIE4  PARAMS: V0={Vth_final}
XM1  midL   vcompn  sn    IGZO_DIE4  PARAMS: V0={Vth_final}
XM0  midL   sn      vbl_l IGZO_DIE4  PARAMS: V0={Vth_final}
CSN  sn     0  100f  IC=-1.5

* 오른쪽 브랜치 (대칭)
XM5  vml    vreadn  midR  IGZO_DIE4  PARAMS: V0={Vth_final}
XM4  midR   vcompn  snb   IGZO_DIE4  PARAMS: V0={Vth_final}
XM3  midR   snb     vbl_r IGZO_DIE4  PARAMS: V0={Vth_final}
CSNB snb    0  100f  IC=-1.5

RLEAK_L   sn    0  10G
RLEAK_R   snb   0  10G
RMID_L    midL  0  10G
RMID_R    midR  0  10G

.OPTIONS TIMEINT METHOD=TRAP ABSTOL=1e-14 RELTOL=1e-4
.OPTIONS NONLIN CONTINUATION=1

.TRAN 1n 500000u UIC

.PRINT TRAN FORMAT=CSV  TIME  V(sn)  V(snb)  V(midL)  V(midR)  V(vreadn)  V(vcompn)  V(vbl_l)  V(vbl_r)
+ I(VVML)  I(VVCOMP)  I(VVREAD)  I(VBL_L)  I(VBL_R)

.END
