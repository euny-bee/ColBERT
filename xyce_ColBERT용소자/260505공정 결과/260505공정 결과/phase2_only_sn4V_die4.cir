* ============================================================
* [실험] Phase1(precharge) 없이, SN 초기값을 +4V(SNB는 -4V)로 강제로 주고
*        Phase2(store)만 바로 진행 -- Vth=3.03V에서도 Vgs_M0=4-(-1)=5V > Vth로
*        시작부터 M0가 세게 켜지도록 만들었을 때 어디로 수렴하는지 확인
* ============================================================

.TITLE Phase2-only, SN_initial=+4V, Vth sweep

.INCLUDE igzo_die4.sub

.PARAM Vth_final = 0.03
.STEP Vth_final LIST 0.03 0.53 1.03 2.03 3.03

VVML    vml    0  DC 0.0
VVCOMP  vcompn 0  DC 3.0
VVREAD  vreadn 0  DC -3.0
VBL_L   vbl_l  0  DC -1.0
VBL_R   vbl_r  0  DC  1.0

XM2  vml    vreadn  midL  IGZO_DIE4  PARAMS: V0={Vth_final}
XM1  midL   vcompn  sn    IGZO_DIE4  PARAMS: V0={Vth_final}
XM0  midL   sn      vbl_l IGZO_DIE4  PARAMS: V0={Vth_final}
CSN  sn     0  100f  IC=4.0

XM5  vml    vreadn  midR  IGZO_DIE4  PARAMS: V0={Vth_final}
XM4  midR   vcompn  snb   IGZO_DIE4  PARAMS: V0={Vth_final}
XM3  midR   snb     vbl_r IGZO_DIE4  PARAMS: V0={Vth_final}
CSNB snb    0  100f  IC=-4.0

RLEAK_L   sn    0  10G
RLEAK_R   snb   0  10G
RMID_L    midL  0  10G
RMID_R    midR  0  10G

.OPTIONS TIMEINT METHOD=TRAP ABSTOL=1e-14 RELTOL=1e-4
.OPTIONS NONLIN CONTINUATION=1

.TRAN 1n 500000u UIC

.PRINT TRAN FORMAT=CSV  TIME  V(sn)  V(snb)  V(midL)  V(midR)
+ I(VVML)  I(VVCOMP)  I(VVREAD)  I(VBL_L)  I(VBL_R)

.END
