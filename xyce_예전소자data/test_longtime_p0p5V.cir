* 2T1C  Vth+0.5V model, 장시간(500ms) 검증 -- 진짜 평형이 V5(-1V)로 가는지 확인
.TITLE 2T1C Vth+0p5V longtime check
.INCLUDE igzo_smooth_p0p5V.sub
VV3  v3n  0  DC 3.0
VV4  v4n  0  DC 0.0
VV5  v5n  0  DC -1.0
C1  sn  v4n  100f  IC=3
XM1  mid  v3n  sn   IGZO_SMOOTH_P0P5V
XM0  mid  sn   v5n   IGZO_SMOOTH_P0P5V
RBLEED  sn   0  10G
RMID    mid  0  10G
CMID    mid  0  1f
CSN     sn   0  1f
.IC  V(sn)=3  V(mid)=0
.OPTIONS TIMEINT METHOD=TRAP ABSTOL=1e-13 RELTOL=1e-3
.OPTIONS DEVICE GMIN=1e-15
.TRAN 50n 500m UIC
.PRINT TRAN FORMAT=CSV  TIME  V(sn)  V(mid)
.END
