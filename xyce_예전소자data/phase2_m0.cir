* Phase 2 - single M0: V5=1.0V, V̄5=+1.0V, V4 swept -1~1V
* VSN_final = V4 + (Vth - V5) = V4 -0.8898
.INCLUDE igzo_smooth_k5.sub
VV1  v1n  0  DC 0.0
VV2  v2n  0  DC 3.0
VV3  v3n  0  DC -3.0
VV4  v4n  0  DC 0.0
V5B  v5bn 0  DC 1.0       ; V̄5 = +1.0V  (Phase 2, was -1.0V in Phase 1)
BSN  sn   0  V={V(v4n) + -0.8898}
XM2  v1n  v2n  mid  IGZO_SMOOTH_K5
XM1  mid  v3n  sn   IGZO_SMOOTH_K5
XM0  mid  sn   v5bn IGZO_SMOOTH_K5
RMID mid  0  10T
.DC VV4 -1 2 0.02
.PRINT DC FORMAT=CSV V(v4n) V(sn) V(mid) I(V5B)
.END
